* divider (cadlab SPICE netlist, ngspice dialect)
* supplies
VVIN VIN 0 DC 5
C1 OUT 0 100n
D1 LED_A 0 D_LED_red_0603
* J1: Connector (not simulated)
R1 VIN OUT 10k
R2 OUT 0 10k
R3 VIN LED_A 1k
* XU1 BUF BUF OUT 0 NC_U1_5 NC_U1_6 NC_U1_7 VIN OPAMP
.model D_LED_red_0603 D
.control
op
print v(out)
.endc
.end
